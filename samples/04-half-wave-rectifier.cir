* CircuitBench 匯出的 SPICE 子集網表
.title 二極體半波整流
.model D_D1 D(Is=1E-14 N=1)
V1 in 0 SIN(0 10 50 0 0 0)
D1 in out D_D1
RL out 0 1000
.tran 4E-05 0.04 0 2E-05
.end
