* CircuitBench 匯出的 SPICE 子集網表
.title RLC 串聯共振
V1 N$1 0 DC 0 AC 1 0
L1 N$1 N$2 0.01
C1 N$2 out 1E-07
R1 out 0 10
.ac dec 400 1000 20000
.end
