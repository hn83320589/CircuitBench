* CircuitBench 匯出的 SPICE 子集網表
.title 橋式整流加濾波電容
.model D_D1 D(Is=1E-14 N=1)
.model D_D2 D(Is=1E-14 N=1)
.model D_D3 D(Is=1E-14 N=1)
.model D_D4 D(Is=1E-14 N=1)
V1 a b SIN(0 10 50 0 0 0)
D1 a out D_D1
D2 b out D_D2
D3 0 a D_D3
D4 0 b D_D4
RL out 0 1000
CF out 0 0.0001
.tran 0.0001 0.1 0 0.0001
.end
